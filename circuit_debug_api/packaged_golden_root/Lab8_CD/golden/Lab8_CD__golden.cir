* C:\ft\ltspice_llm_pipeline_vnext_20260303\pipeline\out_all_labs_rich_v1_train\Lab8_CD\input_asc\Lab8_CD.asc
* Generated by LTspice 26.0.1 for Windows.
C1 N005 0 10n
C2 N002 N001 10n
R2 N005 N001 15.1k
R1 N001 N004 15.1k
XU2 N005 N002 N003 N006 N002 LM741 ;pnba In+)In-)V+)V-)OUT
V1 N003 0 5
V2 N006 0 -5
V3 N004 0 PULSE(-1 1 0 1u 1u 0.005 0.01 1000)
* Library below included based on ModelFile attribute of instance X§U2 (C:\Users\bchar\OneDrive\Documents\LTspice\LM741.ASY)
.lib LM741.lib
.backanno
.op
.tran 0 10m 0 10u
; AUTO_MEAS_BEGIN
.save V(*)
.save I(C1)
.save I(C2)
.save I(R1)
.save I(R2)
.save I(V1)
.save I(V2)
.save I(V3)
.meas op V_N001 FIND V(N001)
.meas tran V_N001_MAX MAX V(N001)
.meas tran V_N001_MIN MIN V(N001)
.meas tran V_N001_RMS RMS V(N001)
.meas tran V_N001_AVG AVG V(N001)
.meas tran V_N001_PP PP V(N001)
.meas op V_N002 FIND V(N002)
.meas tran V_N002_MAX MAX V(N002)
.meas tran V_N002_MIN MIN V(N002)
.meas tran V_N002_RMS RMS V(N002)
.meas tran V_N002_AVG AVG V(N002)
.meas tran V_N002_PP PP V(N002)
.meas op V_N003 FIND V(N003)
.meas tran V_N003_MAX MAX V(N003)
.meas tran V_N003_MIN MIN V(N003)
.meas tran V_N003_RMS RMS V(N003)
.meas tran V_N003_AVG AVG V(N003)
.meas tran V_N003_PP PP V(N003)
.meas op V_N004 FIND V(N004)
.meas tran V_N004_MAX MAX V(N004)
.meas tran V_N004_MIN MIN V(N004)
.meas tran V_N004_RMS RMS V(N004)
.meas tran V_N004_AVG AVG V(N004)
.meas tran V_N004_PP PP V(N004)
.meas op V_N005 FIND V(N005)
.meas tran V_N005_MAX MAX V(N005)
.meas tran V_N005_MIN MIN V(N005)
.meas tran V_N005_RMS RMS V(N005)
.meas tran V_N005_AVG AVG V(N005)
.meas tran V_N005_PP PP V(N005)
.meas op V_N006 FIND V(N006)
.meas tran V_N006_MAX MAX V(N006)
.meas tran V_N006_MIN MIN V(N006)
.meas tran V_N006_RMS RMS V(N006)
.meas tran V_N006_AVG AVG V(N006)
.meas tran V_N006_PP PP V(N006)
.meas op I_C1 FIND I(C1)
.meas tran I_C1_MAX MAX I(C1)
.meas tran I_C1_MIN MIN I(C1)
.meas tran I_C1_RMS RMS I(C1)
.meas tran I_C1_AVG AVG I(C1)
.meas tran I_C1_PP PP I(C1)
.meas op I_C2 FIND I(C2)
.meas tran I_C2_MAX MAX I(C2)
.meas tran I_C2_MIN MIN I(C2)
.meas tran I_C2_RMS RMS I(C2)
.meas tran I_C2_AVG AVG I(C2)
.meas tran I_C2_PP PP I(C2)
.meas op I_R1 FIND I(R1)
.meas tran I_R1_MAX MAX I(R1)
.meas tran I_R1_MIN MIN I(R1)
.meas tran I_R1_RMS RMS I(R1)
.meas tran I_R1_AVG AVG I(R1)
.meas tran I_R1_PP PP I(R1)
.meas op I_R2 FIND I(R2)
.meas tran I_R2_MAX MAX I(R2)
.meas tran I_R2_MIN MIN I(R2)
.meas tran I_R2_RMS RMS I(R2)
.meas tran I_R2_AVG AVG I(R2)
.meas tran I_R2_PP PP I(R2)
.meas op I_V1 FIND I(V1)
.meas tran I_V1_MAX MAX I(V1)
.meas tran I_V1_MIN MIN I(V1)
.meas tran I_V1_RMS RMS I(V1)
.meas tran I_V1_AVG AVG I(V1)
.meas tran I_V1_PP PP I(V1)
.meas op I_V2 FIND I(V2)
.meas tran I_V2_MAX MAX I(V2)
.meas tran I_V2_MIN MIN I(V2)
.meas tran I_V2_RMS RMS I(V2)
.meas tran I_V2_AVG AVG I(V2)
.meas tran I_V2_PP PP I(V2)
.meas op I_V3 FIND I(V3)
.meas tran I_V3_MAX MAX I(V3)
.meas tran I_V3_MIN MIN I(V3)
.meas tran I_V3_RMS RMS I(V3)
.meas tran I_V3_AVG AVG I(V3)
.meas tran I_V3_PP PP I(V3)
; AUTO_MEAS_END
.end
