* C:\ft\ltspice_llm_pipeline_vnext_20260303\pipeline\out_all_labs_rich_v1_train\Lab2_1_500\input_asc\Lab2_1_500.asc
* Generated by LTspice 26.0.1 for Windows.
V1 N001 0 1.5
R2 0 N001 500
.backanno
.op
.tran 0 10m 0 10u
; AUTO_MEAS_BEGIN
.save V(*)
.save I(R2)
.save I(V1)
.meas op V_N001 FIND V(N001)
.meas tran V_N001_MAX MAX V(N001)
.meas tran V_N001_MIN MIN V(N001)
.meas tran V_N001_RMS RMS V(N001)
.meas tran V_N001_AVG AVG V(N001)
.meas tran V_N001_PP PP V(N001)
.meas op I_R2 FIND I(R2)
.meas tran I_R2_MAX MAX I(R2)
.meas tran I_R2_MIN MIN I(R2)
.meas tran I_R2_RMS RMS I(R2)
.meas tran I_R2_AVG AVG I(R2)
.meas tran I_R2_PP PP I(R2)
.meas op I_V1 FIND I(V1)
.meas tran I_V1_MAX MAX I(V1)
.meas tran I_V1_MIN MIN I(V1)
.meas tran I_V1_RMS RMS I(V1)
.meas tran I_V1_AVG AVG I(V1)
.meas tran I_V1_PP PP I(V1)
; AUTO_MEAS_END
.end
