* C:\ft\ltspice_llm_pipeline_vnext_20260303\pipeline\out_all_labs_rich_v1_train\Lab5_1\input_asc\Lab5_1.asc
* Generated by LTspice 26.0.1 for Windows.
XU1 N003 N005 N001 N009 N006 LM339 ;pnba In+)In-)V+)V-)OUT
XU2 0 N004 N001 N009 N007 LM741 ;pnba In+)In-)V+)V-)OUT
XU3 N008 N002 N001 N009 N003 LM741 ;pnba In+)In-)V+)V-)OUT
R1 N007 N004 100000
R2 N008 N007 2200
R3 N002 0 1000
R4 N003 N002 3300
R5 N001 N005 1000
R6 N005 0 1000
D2 N001 P001 1N4148
R7 P001 N006 5000
R8 N006 P002 5000
D3 P002 0 1N4148
V2 N001 0 5
V3 N009 0 -5
R9 N001 N006 10000
I1 0 N004 0.055
.model D D
.lib C:\Users\bchar\AppData\Local\LTspice\lib\cmp\standard.dio
.include "C:\ft\LTSpice_files\Lab4\Task 3\LM339.lib"
* Library below included based on ModelFile attribute of instance X§U2, X§U3 (C:\Users\bchar\OneDrive\Documents\LTspice\LM741.ASY)
.lib LM741.lib
.backanno
.op
.tran 0 10m 0 10u
; AUTO_MEAS_BEGIN
.save V(*)
.save I(D2)
.save I(D3)
.save I(I1)
.save I(R1)
.save I(R2)
.save I(R3)
.save I(R4)
.save I(R5)
.save I(R6)
.save I(R7)
.save I(R8)
.save I(R9)
.save I(V2)
.save I(V3)
.meas op V_N001 FIND V(N001)
.meas tran V_N001_MAX MAX V(N001)
.meas tran V_N001_MIN MIN V(N001)
.meas tran V_N001_RMS RMS V(N001)
.meas tran V_N001_AVG AVG V(N001)
.meas tran V_N001_PP PP V(N001)
.meas op V_N002 FIND V(N002)
.meas tran V_N002_MAX MAX V(N002)
.meas tran V_N002_MIN MIN V(N002)
.meas tran V_N002_RMS RMS V(N002)
.meas tran V_N002_AVG AVG V(N002)
.meas tran V_N002_PP PP V(N002)
.meas op V_N003 FIND V(N003)
.meas tran V_N003_MAX MAX V(N003)
.meas tran V_N003_MIN MIN V(N003)
.meas tran V_N003_RMS RMS V(N003)
.meas tran V_N003_AVG AVG V(N003)
.meas tran V_N003_PP PP V(N003)
.meas op V_N004 FIND V(N004)
.meas tran V_N004_MAX MAX V(N004)
.meas tran V_N004_MIN MIN V(N004)
.meas tran V_N004_RMS RMS V(N004)
.meas tran V_N004_AVG AVG V(N004)
.meas tran V_N004_PP PP V(N004)
.meas op V_N005 FIND V(N005)
.meas tran V_N005_MAX MAX V(N005)
.meas tran V_N005_MIN MIN V(N005)
.meas tran V_N005_RMS RMS V(N005)
.meas tran V_N005_AVG AVG V(N005)
.meas tran V_N005_PP PP V(N005)
.meas op V_N006 FIND V(N006)
.meas tran V_N006_MAX MAX V(N006)
.meas tran V_N006_MIN MIN V(N006)
.meas tran V_N006_RMS RMS V(N006)
.meas tran V_N006_AVG AVG V(N006)
.meas tran V_N006_PP PP V(N006)
.meas op V_N007 FIND V(N007)
.meas tran V_N007_MAX MAX V(N007)
.meas tran V_N007_MIN MIN V(N007)
.meas tran V_N007_RMS RMS V(N007)
.meas tran V_N007_AVG AVG V(N007)
.meas tran V_N007_PP PP V(N007)
.meas op V_N008 FIND V(N008)
.meas tran V_N008_MAX MAX V(N008)
.meas tran V_N008_MIN MIN V(N008)
.meas tran V_N008_RMS RMS V(N008)
.meas tran V_N008_AVG AVG V(N008)
.meas tran V_N008_PP PP V(N008)
.meas op V_N009 FIND V(N009)
.meas tran V_N009_MAX MAX V(N009)
.meas tran V_N009_MIN MIN V(N009)
.meas tran V_N009_RMS RMS V(N009)
.meas tran V_N009_AVG AVG V(N009)
.meas tran V_N009_PP PP V(N009)
.meas op V_P001 FIND V(P001)
.meas tran V_P001_MAX MAX V(P001)
.meas tran V_P001_MIN MIN V(P001)
.meas tran V_P001_RMS RMS V(P001)
.meas tran V_P001_AVG AVG V(P001)
.meas tran V_P001_PP PP V(P001)
.meas op V_P002 FIND V(P002)
.meas tran V_P002_MAX MAX V(P002)
.meas tran V_P002_MIN MIN V(P002)
.meas tran V_P002_RMS RMS V(P002)
.meas tran V_P002_AVG AVG V(P002)
.meas tran V_P002_PP PP V(P002)
.meas op I_D2 FIND I(D2)
.meas tran I_D2_MAX MAX I(D2)
.meas tran I_D2_MIN MIN I(D2)
.meas tran I_D2_RMS RMS I(D2)
.meas tran I_D2_AVG AVG I(D2)
.meas tran I_D2_PP PP I(D2)
.meas op I_D3 FIND I(D3)
.meas tran I_D3_MAX MAX I(D3)
.meas tran I_D3_MIN MIN I(D3)
.meas tran I_D3_RMS RMS I(D3)
.meas tran I_D3_AVG AVG I(D3)
.meas tran I_D3_PP PP I(D3)
.meas op I_I1 FIND I(I1)
.meas tran I_I1_MAX MAX I(I1)
.meas tran I_I1_MIN MIN I(I1)
.meas tran I_I1_RMS RMS I(I1)
.meas tran I_I1_AVG AVG I(I1)
.meas tran I_I1_PP PP I(I1)
.meas op I_R1 FIND I(R1)
.meas tran I_R1_MAX MAX I(R1)
.meas tran I_R1_MIN MIN I(R1)
.meas tran I_R1_RMS RMS I(R1)
.meas tran I_R1_AVG AVG I(R1)
.meas tran I_R1_PP PP I(R1)
.meas op I_R2 FIND I(R2)
.meas tran I_R2_MAX MAX I(R2)
.meas tran I_R2_MIN MIN I(R2)
.meas tran I_R2_RMS RMS I(R2)
.meas tran I_R2_AVG AVG I(R2)
.meas tran I_R2_PP PP I(R2)
.meas op I_R3 FIND I(R3)
.meas tran I_R3_MAX MAX I(R3)
.meas tran I_R3_MIN MIN I(R3)
.meas tran I_R3_RMS RMS I(R3)
.meas tran I_R3_AVG AVG I(R3)
.meas tran I_R3_PP PP I(R3)
.meas op I_R4 FIND I(R4)
.meas tran I_R4_MAX MAX I(R4)
.meas tran I_R4_MIN MIN I(R4)
.meas tran I_R4_RMS RMS I(R4)
.meas tran I_R4_AVG AVG I(R4)
.meas tran I_R4_PP PP I(R4)
.meas op I_R5 FIND I(R5)
.meas tran I_R5_MAX MAX I(R5)
.meas tran I_R5_MIN MIN I(R5)
.meas tran I_R5_RMS RMS I(R5)
.meas tran I_R5_AVG AVG I(R5)
.meas tran I_R5_PP PP I(R5)
.meas op I_R6 FIND I(R6)
.meas tran I_R6_MAX MAX I(R6)
.meas tran I_R6_MIN MIN I(R6)
.meas tran I_R6_RMS RMS I(R6)
.meas tran I_R6_AVG AVG I(R6)
.meas tran I_R6_PP PP I(R6)
.meas op I_R7 FIND I(R7)
.meas tran I_R7_MAX MAX I(R7)
.meas tran I_R7_MIN MIN I(R7)
.meas tran I_R7_RMS RMS I(R7)
.meas tran I_R7_AVG AVG I(R7)
.meas tran I_R7_PP PP I(R7)
.meas op I_R8 FIND I(R8)
.meas tran I_R8_MAX MAX I(R8)
.meas tran I_R8_MIN MIN I(R8)
.meas tran I_R8_RMS RMS I(R8)
.meas tran I_R8_AVG AVG I(R8)
.meas tran I_R8_PP PP I(R8)
.meas op I_R9 FIND I(R9)
.meas tran I_R9_MAX MAX I(R9)
.meas tran I_R9_MIN MIN I(R9)
.meas tran I_R9_RMS RMS I(R9)
.meas tran I_R9_AVG AVG I(R9)
.meas tran I_R9_PP PP I(R9)
.meas op I_V2 FIND I(V2)
.meas tran I_V2_MAX MAX I(V2)
.meas tran I_V2_MIN MIN I(V2)
.meas tran I_V2_RMS RMS I(V2)
.meas tran I_V2_AVG AVG I(V2)
.meas tran I_V2_PP PP I(V2)
.meas op I_V3 FIND I(V3)
.meas tran I_V3_MAX MAX I(V3)
.meas tran I_V3_MIN MIN I(V3)
.meas tran I_V3_RMS RMS I(V3)
.meas tran I_V3_AVG AVG I(V3)
.meas tran I_V3_PP PP I(V3)
; AUTO_MEAS_END
.end
