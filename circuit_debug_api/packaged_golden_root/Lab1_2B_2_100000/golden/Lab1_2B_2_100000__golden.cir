* C:\ft\ltspice_llm_pipeline_vnext_20260303\pipeline\out_all_labs_rich_v1_train\Lab1_2B_2_100000\input_asc\Lab1_2B_2_100000.asc
* Generated by LTspice 26.0.1 for Windows.
V1 N001 0 9
R1 N001 N002 8000
R2 0 N002 10000
R3 N002 0 100000
.op
.backanno
.tran 0 10m 0 10u
; AUTO_MEAS_BEGIN
.save V(*)
.save I(R1)
.save I(R2)
.save I(R3)
.save I(V1)
.meas op V_N001 FIND V(N001)
.meas tran V_N001_MAX MAX V(N001)
.meas tran V_N001_MIN MIN V(N001)
.meas tran V_N001_RMS RMS V(N001)
.meas tran V_N001_AVG AVG V(N001)
.meas tran V_N001_PP PP V(N001)
.meas op V_N002 FIND V(N002)
.meas tran V_N002_MAX MAX V(N002)
.meas tran V_N002_MIN MIN V(N002)
.meas tran V_N002_RMS RMS V(N002)
.meas tran V_N002_AVG AVG V(N002)
.meas tran V_N002_PP PP V(N002)
.meas op I_R1 FIND I(R1)
.meas tran I_R1_MAX MAX I(R1)
.meas tran I_R1_MIN MIN I(R1)
.meas tran I_R1_RMS RMS I(R1)
.meas tran I_R1_AVG AVG I(R1)
.meas tran I_R1_PP PP I(R1)
.meas op I_R2 FIND I(R2)
.meas tran I_R2_MAX MAX I(R2)
.meas tran I_R2_MIN MIN I(R2)
.meas tran I_R2_RMS RMS I(R2)
.meas tran I_R2_AVG AVG I(R2)
.meas tran I_R2_PP PP I(R2)
.meas op I_R3 FIND I(R3)
.meas tran I_R3_MAX MAX I(R3)
.meas tran I_R3_MIN MIN I(R3)
.meas tran I_R3_RMS RMS I(R3)
.meas tran I_R3_AVG AVG I(R3)
.meas tran I_R3_PP PP I(R3)
.meas op I_V1 FIND I(V1)
.meas tran I_V1_MAX MAX I(V1)
.meas tran I_V1_MIN MIN I(V1)
.meas tran I_V1_RMS RMS I(V1)
.meas tran I_V1_AVG AVG I(V1)
.meas tran I_V1_PP PP I(V1)
; AUTO_MEAS_END
.end
