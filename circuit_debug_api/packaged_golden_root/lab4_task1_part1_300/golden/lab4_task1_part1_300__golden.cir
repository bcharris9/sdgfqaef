* C:\ft\ltspice_llm_pipeline_vnext_20260303\pipeline\out_all_labs_rich_v1_train\lab4_task1_part1_300\input_asc\lab4_task1_part1_300.asc
* Generated by LTspice 26.0.1 for Windows.
V1 N001 0 5
D1 N001 VE 1N4148
R1 VE 0 300
.model D D
.lib C:\Users\bchar\AppData\Local\LTspice\lib\cmp\standard.dio
.backanno
.op
.tran 0 10m 0 10u
; AUTO_MEAS_BEGIN
.save V(*)
.save I(D1)
.save I(R1)
.save I(V1)
.meas op V_N001 FIND V(N001)
.meas tran V_N001_MAX MAX V(N001)
.meas tran V_N001_MIN MIN V(N001)
.meas tran V_N001_RMS RMS V(N001)
.meas tran V_N001_AVG AVG V(N001)
.meas tran V_N001_PP PP V(N001)
.meas op V_VE FIND V(VE)
.meas tran V_VE_MAX MAX V(VE)
.meas tran V_VE_MIN MIN V(VE)
.meas tran V_VE_RMS RMS V(VE)
.meas tran V_VE_AVG AVG V(VE)
.meas tran V_VE_PP PP V(VE)
.meas op I_D1 FIND I(D1)
.meas tran I_D1_MAX MAX I(D1)
.meas tran I_D1_MIN MIN I(D1)
.meas tran I_D1_RMS RMS I(D1)
.meas tran I_D1_AVG AVG I(D1)
.meas tran I_D1_PP PP I(D1)
.meas op I_R1 FIND I(R1)
.meas tran I_R1_MAX MAX I(R1)
.meas tran I_R1_MIN MIN I(R1)
.meas tran I_R1_RMS RMS I(R1)
.meas tran I_R1_AVG AVG I(R1)
.meas tran I_R1_PP PP I(R1)
.meas op I_V1 FIND I(V1)
.meas tran I_V1_MAX MAX I(V1)
.meas tran I_V1_MIN MIN I(V1)
.meas tran I_V1_RMS RMS I(V1)
.meas tran I_V1_AVG AVG I(V1)
.meas tran I_V1_PP PP I(V1)
; AUTO_MEAS_END
.end
