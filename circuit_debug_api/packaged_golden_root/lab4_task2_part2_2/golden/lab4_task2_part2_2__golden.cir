* C:\ft\ltspice_llm_pipeline_vnext_20260303\pipeline\out_all_labs_rich_v1_train\lab4_task2_part2_2\input_asc\lab4_task2_part2_2.asc
* Generated by LTspice 26.0.1 for Windows.
R1 N001 0 1000
R2 Vout N001 2000
V1 N003 0 2
V2 VCC 0 5
V3 -VCC 0 -5
XU1 N002 N001 VCC -VCC Vout LM741 ;pnba In+)In-)V+)V-)OUT
R3 N002 N003 2000
* Library below included based on ModelFile attribute of instance X§U1 (C:\Users\bchar\OneDrive\Documents\LTspice\LM741.ASY)
.lib LM741.lib
.backanno
.op
.tran 0 10m 0 10u
; AUTO_MEAS_BEGIN
.save V(*)
.save I(R1)
.save I(R2)
.save I(R3)
.save I(V1)
.save I(V2)
.save I(V3)
.meas op V__VCC FIND V(-VCC)
.meas tran V__VCC_MAX MAX V(-VCC)
.meas tran V__VCC_MIN MIN V(-VCC)
.meas tran V__VCC_RMS RMS V(-VCC)
.meas tran V__VCC_AVG AVG V(-VCC)
.meas tran V__VCC_PP PP V(-VCC)
.meas op V_N001 FIND V(N001)
.meas tran V_N001_MAX MAX V(N001)
.meas tran V_N001_MIN MIN V(N001)
.meas tran V_N001_RMS RMS V(N001)
.meas tran V_N001_AVG AVG V(N001)
.meas tran V_N001_PP PP V(N001)
.meas op V_N002 FIND V(N002)
.meas tran V_N002_MAX MAX V(N002)
.meas tran V_N002_MIN MIN V(N002)
.meas tran V_N002_RMS RMS V(N002)
.meas tran V_N002_AVG AVG V(N002)
.meas tran V_N002_PP PP V(N002)
.meas op V_N003 FIND V(N003)
.meas tran V_N003_MAX MAX V(N003)
.meas tran V_N003_MIN MIN V(N003)
.meas tran V_N003_RMS RMS V(N003)
.meas tran V_N003_AVG AVG V(N003)
.meas tran V_N003_PP PP V(N003)
.meas op V_VCC FIND V(VCC)
.meas tran V_VCC_MAX MAX V(VCC)
.meas tran V_VCC_MIN MIN V(VCC)
.meas tran V_VCC_RMS RMS V(VCC)
.meas tran V_VCC_AVG AVG V(VCC)
.meas tran V_VCC_PP PP V(VCC)
.meas op V_Vout FIND V(Vout)
.meas tran V_Vout_MAX MAX V(Vout)
.meas tran V_Vout_MIN MIN V(Vout)
.meas tran V_Vout_RMS RMS V(Vout)
.meas tran V_Vout_AVG AVG V(Vout)
.meas tran V_Vout_PP PP V(Vout)
.meas op I_R1 FIND I(R1)
.meas tran I_R1_MAX MAX I(R1)
.meas tran I_R1_MIN MIN I(R1)
.meas tran I_R1_RMS RMS I(R1)
.meas tran I_R1_AVG AVG I(R1)
.meas tran I_R1_PP PP I(R1)
.meas op I_R2 FIND I(R2)
.meas tran I_R2_MAX MAX I(R2)
.meas tran I_R2_MIN MIN I(R2)
.meas tran I_R2_RMS RMS I(R2)
.meas tran I_R2_AVG AVG I(R2)
.meas tran I_R2_PP PP I(R2)
.meas op I_R3 FIND I(R3)
.meas tran I_R3_MAX MAX I(R3)
.meas tran I_R3_MIN MIN I(R3)
.meas tran I_R3_RMS RMS I(R3)
.meas tran I_R3_AVG AVG I(R3)
.meas tran I_R3_PP PP I(R3)
.meas op I_V1 FIND I(V1)
.meas tran I_V1_MAX MAX I(V1)
.meas tran I_V1_MIN MIN I(V1)
.meas tran I_V1_RMS RMS I(V1)
.meas tran I_V1_AVG AVG I(V1)
.meas tran I_V1_PP PP I(V1)
.meas op I_V2 FIND I(V2)
.meas tran I_V2_MAX MAX I(V2)
.meas tran I_V2_MIN MIN I(V2)
.meas tran I_V2_RMS RMS I(V2)
.meas tran I_V2_AVG AVG I(V2)
.meas tran I_V2_PP PP I(V2)
.meas op I_V3 FIND I(V3)
.meas tran I_V3_MAX MAX I(V3)
.meas tran I_V3_MIN MIN I(V3)
.meas tran I_V3_RMS RMS I(V3)
.meas tran I_V3_AVG AVG I(V3)
.meas tran I_V3_PP PP I(V3)
; AUTO_MEAS_END
.end
