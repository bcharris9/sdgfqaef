* C:\ft\ltspice_llm_pipeline_vnext_20260303\pipeline\out_all_labs_rich_v1_train\Lab6_1\input_asc\Lab6_1.asc
* Generated by LTspice 26.0.1 for Windows.
R1 N002 N001 5.1k
R2 N001 0 5.1k
V1 VCC 0 5
V2 -VCC 0 -5
C1 N003 0 10u
D1 N004 0 D
D2 0 N004 D
R N002 N003 100000
R3 N004 N002 1k
XU2 N001 N003 VCC -VCC N002 LM741 ;pnba In+)In-)V+)V-)OUT
.model D D
.lib C:\Users\bchar\AppData\Local\LTspice\lib\cmp\standard.dio
.ic V(N001)=0.1
* Library below included based on ModelFile attribute of instance X§U2 (C:\Users\bchar\OneDrive\Documents\LTspice\LM741.ASY)
.lib LM741.lib
.backanno
.op
.tran 0 10m 0 10u
; AUTO_MEAS_BEGIN
.save V(*)
.save I(C1)
.save I(D1)
.save I(D2)
.save I(R)
.save I(R1)
.save I(R2)
.save I(R3)
.save I(V1)
.save I(V2)
.meas op V__VCC FIND V(-VCC)
.meas tran V__VCC_MAX MAX V(-VCC)
.meas tran V__VCC_MIN MIN V(-VCC)
.meas tran V__VCC_RMS RMS V(-VCC)
.meas tran V__VCC_AVG AVG V(-VCC)
.meas tran V__VCC_PP PP V(-VCC)
.meas op V_N001 FIND V(N001)
.meas tran V_N001_MAX MAX V(N001)
.meas tran V_N001_MIN MIN V(N001)
.meas tran V_N001_RMS RMS V(N001)
.meas tran V_N001_AVG AVG V(N001)
.meas tran V_N001_PP PP V(N001)
.meas op V_N002 FIND V(N002)
.meas tran V_N002_MAX MAX V(N002)
.meas tran V_N002_MIN MIN V(N002)
.meas tran V_N002_RMS RMS V(N002)
.meas tran V_N002_AVG AVG V(N002)
.meas tran V_N002_PP PP V(N002)
.meas op V_N003 FIND V(N003)
.meas tran V_N003_MAX MAX V(N003)
.meas tran V_N003_MIN MIN V(N003)
.meas tran V_N003_RMS RMS V(N003)
.meas tran V_N003_AVG AVG V(N003)
.meas tran V_N003_PP PP V(N003)
.meas op V_N004 FIND V(N004)
.meas tran V_N004_MAX MAX V(N004)
.meas tran V_N004_MIN MIN V(N004)
.meas tran V_N004_RMS RMS V(N004)
.meas tran V_N004_AVG AVG V(N004)
.meas tran V_N004_PP PP V(N004)
.meas op V_VCC FIND V(VCC)
.meas tran V_VCC_MAX MAX V(VCC)
.meas tran V_VCC_MIN MIN V(VCC)
.meas tran V_VCC_RMS RMS V(VCC)
.meas tran V_VCC_AVG AVG V(VCC)
.meas tran V_VCC_PP PP V(VCC)
.meas op I_C1 FIND I(C1)
.meas tran I_C1_MAX MAX I(C1)
.meas tran I_C1_MIN MIN I(C1)
.meas tran I_C1_RMS RMS I(C1)
.meas tran I_C1_AVG AVG I(C1)
.meas tran I_C1_PP PP I(C1)
.meas op I_D1 FIND I(D1)
.meas tran I_D1_MAX MAX I(D1)
.meas tran I_D1_MIN MIN I(D1)
.meas tran I_D1_RMS RMS I(D1)
.meas tran I_D1_AVG AVG I(D1)
.meas tran I_D1_PP PP I(D1)
.meas op I_D2 FIND I(D2)
.meas tran I_D2_MAX MAX I(D2)
.meas tran I_D2_MIN MIN I(D2)
.meas tran I_D2_RMS RMS I(D2)
.meas tran I_D2_AVG AVG I(D2)
.meas tran I_D2_PP PP I(D2)
.meas op I_R FIND I(R)
.meas tran I_R_MAX MAX I(R)
.meas tran I_R_MIN MIN I(R)
.meas tran I_R_RMS RMS I(R)
.meas tran I_R_AVG AVG I(R)
.meas tran I_R_PP PP I(R)
.meas op I_R1 FIND I(R1)
.meas tran I_R1_MAX MAX I(R1)
.meas tran I_R1_MIN MIN I(R1)
.meas tran I_R1_RMS RMS I(R1)
.meas tran I_R1_AVG AVG I(R1)
.meas tran I_R1_PP PP I(R1)
.meas op I_R2 FIND I(R2)
.meas tran I_R2_MAX MAX I(R2)
.meas tran I_R2_MIN MIN I(R2)
.meas tran I_R2_RMS RMS I(R2)
.meas tran I_R2_AVG AVG I(R2)
.meas tran I_R2_PP PP I(R2)
.meas op I_R3 FIND I(R3)
.meas tran I_R3_MAX MAX I(R3)
.meas tran I_R3_MIN MIN I(R3)
.meas tran I_R3_RMS RMS I(R3)
.meas tran I_R3_AVG AVG I(R3)
.meas tran I_R3_PP PP I(R3)
.meas op I_V1 FIND I(V1)
.meas tran I_V1_MAX MAX I(V1)
.meas tran I_V1_MIN MIN I(V1)
.meas tran I_V1_RMS RMS I(V1)
.meas tran I_V1_AVG AVG I(V1)
.meas tran I_V1_PP PP I(V1)
.meas op I_V2 FIND I(V2)
.meas tran I_V2_MAX MAX I(V2)
.meas tran I_V2_MIN MIN I(V2)
.meas tran I_V2_RMS RMS I(V2)
.meas tran I_V2_AVG AVG I(V2)
.meas tran I_V2_PP PP I(V2)
; AUTO_MEAS_END
.end
