* C:\ft\ltspice_llm_pipeline_vnext_20260303\pipeline\out_all_labs_rich_v1_train\Lab3_1\input_asc\Lab3_1.asc
* Generated by LTspice 26.0.1 for Windows.
V2 N004 0 2
V1 N002 0 5
R1 N002 N001 5.1k
R2 0 N001 2k
R3 N004 N003 2k
R4 N001 N003 1k
R5 0 N003 5.1k
.backanno
.op
.tran 0 10m 0 10u
; AUTO_MEAS_BEGIN
.save V(*)
.save I(R1)
.save I(R2)
.save I(R3)
.save I(R4)
.save I(R5)
.save I(V1)
.save I(V2)
.meas op V_N001 FIND V(N001)
.meas tran V_N001_MAX MAX V(N001)
.meas tran V_N001_MIN MIN V(N001)
.meas tran V_N001_RMS RMS V(N001)
.meas tran V_N001_AVG AVG V(N001)
.meas tran V_N001_PP PP V(N001)
.meas op V_N002 FIND V(N002)
.meas tran V_N002_MAX MAX V(N002)
.meas tran V_N002_MIN MIN V(N002)
.meas tran V_N002_RMS RMS V(N002)
.meas tran V_N002_AVG AVG V(N002)
.meas tran V_N002_PP PP V(N002)
.meas op V_N003 FIND V(N003)
.meas tran V_N003_MAX MAX V(N003)
.meas tran V_N003_MIN MIN V(N003)
.meas tran V_N003_RMS RMS V(N003)
.meas tran V_N003_AVG AVG V(N003)
.meas tran V_N003_PP PP V(N003)
.meas op V_N004 FIND V(N004)
.meas tran V_N004_MAX MAX V(N004)
.meas tran V_N004_MIN MIN V(N004)
.meas tran V_N004_RMS RMS V(N004)
.meas tran V_N004_AVG AVG V(N004)
.meas tran V_N004_PP PP V(N004)
.meas op I_R1 FIND I(R1)
.meas tran I_R1_MAX MAX I(R1)
.meas tran I_R1_MIN MIN I(R1)
.meas tran I_R1_RMS RMS I(R1)
.meas tran I_R1_AVG AVG I(R1)
.meas tran I_R1_PP PP I(R1)
.meas op I_R2 FIND I(R2)
.meas tran I_R2_MAX MAX I(R2)
.meas tran I_R2_MIN MIN I(R2)
.meas tran I_R2_RMS RMS I(R2)
.meas tran I_R2_AVG AVG I(R2)
.meas tran I_R2_PP PP I(R2)
.meas op I_R3 FIND I(R3)
.meas tran I_R3_MAX MAX I(R3)
.meas tran I_R3_MIN MIN I(R3)
.meas tran I_R3_RMS RMS I(R3)
.meas tran I_R3_AVG AVG I(R3)
.meas tran I_R3_PP PP I(R3)
.meas op I_R4 FIND I(R4)
.meas tran I_R4_MAX MAX I(R4)
.meas tran I_R4_MIN MIN I(R4)
.meas tran I_R4_RMS RMS I(R4)
.meas tran I_R4_AVG AVG I(R4)
.meas tran I_R4_PP PP I(R4)
.meas op I_R5 FIND I(R5)
.meas tran I_R5_MAX MAX I(R5)
.meas tran I_R5_MIN MIN I(R5)
.meas tran I_R5_RMS RMS I(R5)
.meas tran I_R5_AVG AVG I(R5)
.meas tran I_R5_PP PP I(R5)
.meas op I_V1 FIND I(V1)
.meas tran I_V1_MAX MAX I(V1)
.meas tran I_V1_MIN MIN I(V1)
.meas tran I_V1_RMS RMS I(V1)
.meas tran I_V1_AVG AVG I(V1)
.meas tran I_V1_PP PP I(V1)
.meas op I_V2 FIND I(V2)
.meas tran I_V2_MAX MAX I(V2)
.meas tran I_V2_MIN MIN I(V2)
.meas tran I_V2_RMS RMS I(V2)
.meas tran I_V2_AVG AVG I(V2)
.meas tran I_V2_PP PP I(V2)
; AUTO_MEAS_END
.end
